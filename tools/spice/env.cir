* SP-1200 dynamic filter cutoff control network, channel 1 (CNL0)
*
* Read from the SP-1200 service manual, schematic SK103 rev D, page 16 of 18
* "Dynamic Filters" (sp1200_service.pdf page 85). Cross-checked against the
* SP-12 service manual, S-7600-001 page 20 of 21 (sp12_service.pdf page 82):
* same values and topology. Channel 2 (CNL1) uses identical values: D8 1N914,
* R96 100, R101 30K, C109 10uF, R97 15K, R113 390, R102 39K, R89 220K, RT5 10K,
* driven by -GAIN2.D instead of +GAIN1.D.
*
* +GAIN1.D comes from IC31 74HCT273 output QF (SK103 page 5), a CMOS output
* swinging 0 to 5 V, modelled as an ideal pulse source through rdrv (the HCT
* output resistance is not on the drawing; ideal by default). The same latch
* bits also select the sample preamp gain (IC102 4053, SK103 page 6).
* D9 anode is on the R98 side, cathode on the GAIN line: a low line discharges
* C111 through R98 and D9; a high line leaves D9 reverse biased (C111 rests just
* below 5 V) and C111 recharges toward +15 V through R135.
* SSM2044 pin 13 (FREQ) is modelled as an open circuit; the data sheet gives no
* input impedance for it, and the node impedance here is under 390 ohms.
*
* Part 1, transient: GAIN high (rest), low for 5 ms from t = 1 ms, then high.
* Part 2, DC: pin 13 voltage against a forced capacitor voltage 0 to 15 V, with
* the RT6 wiper at its -15 V end (CW), centre, and +15 V end (CCW).

.param rdrv=1m
.param ptran=0.5

.model D1N914 D(Is=2.52n Rs=0.568 N=1.752 Cjo=4p M=0.4 Tt=20n Bv=75 Ibv=5u)

VP15 p15 0 DC 15 ; +15 V rail
VM15 m15 0 DC -15 ; -15 V rail

* part 1: transient network
VGAIN gdrv 0 DC 5 PULSE(5 0 1m 50n 50n 5m 10) ; +GAIN1.D, IC31 74HCT273 pin 15 (QF), SK103 p5
RDRV gdrv gain {rdrv} ; 74HCT273 output resistance, not on the drawing (ideal by default)
D9 nd gain D1N914 ; D9 1N914, SK103 p16, cathode to +GAIN1.D
R98 cap nd 100 ; R98 100 5%, SK103 p16
R135 p15 cap 30k ; R135 30K 5%, SK103 p16
C111 cap 0 10u ; C111 10uF 16V tant, SK103 p16, + to the R135 node
R125 cap pin13 15k ; R125 15K 5%, SK103 p16
R118 pin13 0 390 ; R118 390 5%, SK103 p16
R112 pin13 m15 39k ; R112 39K 5%, SK103 p16
R104 pin13 wtr 220k ; R104 220K 5%, SK103 p16
RRT6A m15 wtr {max(10k*ptran,1m)} ; RT6 10K 1-turn trimmer, CW end at -15 V, SK103 p16
RRT6B wtr p15 {max(10k*(1-ptran),1m)} ; RT6 10K 1-turn trimmer, other end at +15 V, SK103 p16

* part 2: DC relation, three copies of the R125 network driven by a forced capacitor voltage
VCS cs 0 DC 0 ; forced C111 voltage
R125_CW cs xcw 15k ; R125 15K 5%, SK103 p16
R118_CW xcw 0 390 ; R118 390 5%, SK103 p16
R112_CW xcw m15 39k ; R112 39K 5%, SK103 p16
R104_CW xcw wcw 220k ; R104 220K 5%, SK103 p16
RRT6A_CW m15 wcw 1m ; RT6 wiper at the -15 V (CW) end, SK103 p16
RRT6B_CW wcw p15 10k ; RT6 remainder, SK103 p16
R125_MID cs xmid 15k ; R125 15K 5%, SK103 p16
R118_MID xmid 0 390 ; R118 390 5%, SK103 p16
R112_MID xmid m15 39k ; R112 39K 5%, SK103 p16
R104_MID xmid wmid 220k ; R104 220K 5%, SK103 p16
RRT6A_MID m15 wmid 5k ; RT6 wiper at centre, SK103 p16
RRT6B_MID wmid p15 5k ; RT6 wiper at centre, SK103 p16
R125_CCW cs xccw 15k ; R125 15K 5%, SK103 p16
R118_CCW xccw 0 390 ; R118 390 5%, SK103 p16
R112_CCW xccw m15 39k ; R112 39K 5%, SK103 p16
R104_CCW xccw wccw 220k ; R104 220K 5%, SK103 p16
RRT6A_CCW m15 wccw 10k ; RT6 remainder, SK103 p16
RRT6B_CCW wccw p15 1m ; RT6 wiper at the +15 V (CCW) end, SK103 p16

.control
set wr_singlescale
set wr_vecnames
option numdgt=8
tran 10u 0.8 0 50u
let gain_v = v(gain)
let cap_v = v(cap)
let pin13_v = v(pin13)
wrdata env.dat gain_v cap_v pin13_v
dc VCS 0 15 0.05
let pin13_cw_v = v(xcw)
let pin13_mid_v = v(xmid)
let pin13_ccw_v = v(xccw)
wrdata env_dc.dat pin13_cw_v pin13_mid_v pin13_ccw_v
.endc

.end
