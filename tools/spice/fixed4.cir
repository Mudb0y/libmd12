* SP-1200 output 4 (+CNLSH3.V, CNL3 OUT) fixed filter, hold buffer output to jack J15 ring
*
* Read from the SP-1200 service manual, schematic SK103 rev D, page 17 of 18
* "Output Channels" (sp1200_service.pdf page 86). Cross-checked against the
* SP-12 service manual, S-7600-001 page 19 of 21 (sp12_service.pdf page 81):
* every filter value agrees. Topology: a passive RC pole (R80, C114) feeding two
* unity-gain Sallen-Key sections (IC122 followers), each with the 0.01 uF on the
* first node returned to the follower output and 1000 pF to ground on the
* follower input. The filtered signal leaves through R130 1.0K to the jack ring;
* the unfiltered hold signal goes to the jack tip through R158 1.0K (flat, not
* simulated). The ring is unloaded: with a plug in the jack its switch is open,
* so R60 22K to the mix bus is disconnected. Capacitor ground returns go to a
* bus tied to board ground and the jack sleeve (AC ground). Op-amps are ideal.

.subckt OPAMP inp inn out
E1 out 0 inp inn 1e7
.ends

V1 in 0 DC 0 AC 1 ; +CNLSH3.V, hold buffer output (SK103 p15), ideal source

R80 in na 6.2k ; R80 6.2k 5%, SK103 p17
C114 na 0 4700p ; C114 4700pF 10%, SK103 p17
R87 na nb 3.0k ; R87 3.0k 5%, SK103 p17
R109 nb nc 5.1k ; R109 5.1k 5%, SK103 p17
C122 nc 0 1000p ; C122 1000pF 10%, SK103 p17
C128 nb o1 0.01u ; C128 0.01uF 10%, SK103 p17, to follower output
XIC122_5_6_7 nc o1 o1 OPAMP ; IC122 TL084 follower, SK103 p17
R94 o1 nd 5.1k ; R94 5.1k 5%, SK103 p17
R121 nd ne 5.1k ; R121 5.1k 5%, SK103 p17
C134 ne 0 1000p ; C134 1000pF 10%, SK103 p17
C140 nd o2 0.01u ; C140 0.01uF 10%, SK103 p17, to follower output
XIC122_1_2_3 ne o2 o2 OPAMP ; IC122 TL084 follower, SK103 p17
R130 o2 ring 1.0k ; R130 1.0K 5%, SK103 p17, to J15 pin 7 (ring)

.control
set wr_singlescale
set wr_vecnames
option numdgt=8
ac dec 400 10 100k
let mag_db = db(v(ring))
let phase_deg = 180/pi*ph(v(ring))
wrdata fixed4.dat mag_db phase_deg
.endc

.end
